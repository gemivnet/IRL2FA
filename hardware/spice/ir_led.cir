* IR emitter drive: VBAT -> R8 100 ohm -> D4 -> Q4 (AO3400A) switched by
* USART1_TX. LED current must stay between 10 and 25 mA from a nearly flat
* cell (2.5 V) to a fresh one (3.2 V).
.include models.lib
Vbat vbat 0 3.2
R8 vbat a 100
D4 a k IRLED
XQ4 k g 0 NFET_LED
Vtx g 0 0
.dc Vbat 2.5 3.2 0.7 Vtx 2.5 2.5 1
.control
op
alter Vtx dc=2.5
alter Vbat dc=3.2
op
let ihi = -i(Vbat)
echo "RESULT iled_fresh $&ihi"
alter Vbat dc=2.5
alter Vtx dc=2.5
op
let ilo = -i(Vbat)
echo "RESULT iled_flat $&ilo"
quit
.endc
.end
