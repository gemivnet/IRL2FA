* IR receiver: VEMT2523SLX01 phototransistor as an emitter follower (collector on
* IR_RX_PWR = VDD, emitter on IR_RX, R10 10 k to GND) read by USART1_RX at 4800 baud.
* Checks that a lone "1" bit after a long idle, and a lone "0" bit after five "1"s,
* cross the STM32U0 input thresholds (VIH 0.7 VDD, VIL 0.3 VDD; DS14548 Table 64)
* at the bit centre, where the USART samples, from a nearly flat cell (VDD 2.5 V).
*
* Phototransistor: a photocurrent source shaped by a first-order lag. 35 us 10-90 %
* rise/fall is the slow end of VEMT2523SLX01 Fig. 4 (tr/tf 20-35 us around
* 0.25-1 mA; Vishay doc 84167 p.3). The emitter follower has its collector at a
* fixed voltage, so there is no Miller slow-down from R10. Saturation: the device
* cannot pull the emitter above VDD - VCEsat (0.4 V max, p.2).
*
* Signal: worst-case parts 2 cm apart on axis. VSMB2948SL at 12.5 mA (flat cell,
* ir_led.cir) gives Ie >= 10 mW/sr x 12.5/100 = 1.25 mW/sr (doc 83498 p.2, min at
* 100 mA, scaled linearly), E = 1.25 / 2^2 = 0.31 mW/cm2, Ica >= 1.3 mA per mW/cm2
* (doc 84167 p.2, min) -> 0.41 mA. The 3 cm case (0.18 mA) is printed, not checked:
* it is the range limit with worst-case parts (docs/electrical-review.md, IR-2).
* Ambient light adds a DC photocurrent; RESULT iamb_max is the most the "0" level
* tolerates (VIL / R10) with no signal.
* SPDX-License-Identifier: CERN-OHL-S-2.0
.param vdd=2.5 isig=0.41m iamb=0 tb={1/4800} tau={35u/2.2}
Vdd vdd 0 {vdd}
* bit pattern (1 = light): idle 0 for 10 bits, lone 1, 0, five 1s, lone 0, then idle
Vpat pat 0 PWL(0 0 {10*tb} 0 {10*tb+1n} 1 {11*tb} 1 {11*tb+1n} 0 {12*tb} 0 {12*tb+1n} 1
+ {17*tb} 1 {17*tb+1n} 0 {18*tb} 0 {18*tb+1n} 1 {19*tb} 1 {19*tb+1n} 0 {30*tb} 0)
Rf pat f 1k
Cf f 0 {tau/1k}
* photo-current with compliance: falls to zero as the emitter nears VDD - 0.4 V
Bph vdd e I = ({iamb} + {isig}*V(f)) * (1 - exp(-max(V(vdd,e)-0.4, 0)/0.05))
R10 e 0 10k
Cin e 0 30p
.tran 1u {30*tb}
.control
run
meas tran v1_mid FIND v(e) AT=2.1875e-3
meas tran v0_mid FIND v(e) AT=3.6458e-3
echo "RESULT v1_mid $&v1_mid"
echo "RESULT v0_mid $&v0_mid"
alterparam isig=0.18m
reset
run
meas tran v1_3cm FIND v(e) AT=2.1875e-3
echo "RESULT v1_mid_3cm $&v1_3cm"
let iamb_max = 0.3*2.5/10e3
echo "RESULT iamb_max $&iamb_max"
quit
.endc
.end
